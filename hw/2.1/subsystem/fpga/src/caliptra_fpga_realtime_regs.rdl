// SPDX-License-Identifier: Apache-2.0
//
// Licensed under the Apache License, Version 2.0 (the "License");
// you may not use this file except in compliance with the License.
// You may obtain a copy of the License at
//
// http://www.apache.org/licenses/LICENSE-2.0
//
// Unless required by applicable law or agreed to in writing, software
// distributed under the License is distributed on an "AS IS" BASIS,
// WITHOUT WARRANTIES OR CONDITIONS OF ANY KIND, either express or implied.
// See the License for the specific language governing permissions and
// limitations under the License.
//

regfile interface_regs {
    reg {
        default sw=r;
        default hw=r;

        field {
            desc = "Ascii \"CPTR\" to check that the image is valid.";
        } fpga_magic[32] = 32'h52545043;
    } fpga_magic;
    reg {
        default sw=r;
        default hw=rw;

        field {
            desc = "Git commit of HEAD the FPGA was built with.";
        } fpga_version[32] = 32'b0;
    } fpga_version;

    reg {
        field { sw=rw; hw=r; } cptra_pwrgood[0:0] = 1'b0;
        field { sw=rw; hw=r; } cptra_ss_rst_b[1:1] = 1'b0;

        field { sw=rw; hw=r; desc = "RSVD in SS"; } cptra_obf_uds_seed_vld[2:2] = 1'b0;
        field { sw=rw; hw=r; desc = "RSVD in SS"; } cptra_obf_field_entropy_vld[3:3] = 1'b0;

        field { sw=rw; hw=r; desc = "RSVD in SS"; } debug_locked[4:4] = 1'b0;
        field { sw=rw; hw=r; desc = "RSVD in SS"; } device_lifecycle[6:5] = 2'b0;
        field { sw=rw; hw=r; } bootfsm_brkpoint[7:7] = 1'b1;
        field { sw=rw; hw=r; desc = "Scan mode for Caliptra Core"; } scan_mode[8:8] = 1'b0;

        field { sw=rw; hw=r; desc = "RSVD in core"; } ss_debug_intent[16:16] = 1'b0;
        field { sw=rw; hw=r; desc = "RSVD in core"; } i3c_axi_user_id_filtering[17:17] = 1'b0;
        field { sw=rw; hw=r; desc = "RSVD in core"; } ocp_lock_en[18:18] = 1'b1;
        field { sw=rw; hw=r; desc = "RSVD in core"; } lc_Allow_RMA_or_SCRAP_on_PPD[19:19] = 1'b0;
        field { sw=rw; hw=r; desc = "RSVD in core"; } FIPS_ZEROIZATION_PPD[20:20] = 1'b0;

        field { sw=rw; hw=r; singlepulse=true; desc = "RSVD in core"; } trigger_axi_reset[31:31] = 1'b0;
    } control;

    reg {
        field { sw=r; hw=rw; desc = "RSVD in SS"; } cptra_error_fatal[0:0] = 1'b0;
        field { sw=r; hw=rw; desc = "RSVD in SS"; } cptra_error_non_fatal[1:1] = 1'b0;

        field { sw=r; hw=rw; desc = "RSVD in SS"; } ready_for_fuses[2:2] = 1'b0;
        field { sw=r; hw=rw; desc = "RSVD in SS"; } ready_for_mb_processing[3:3] = 1'b0;
        field { sw=r; hw=rw; desc = "RSVD in SS"; } ready_for_runtime[4:4] = 1'b0;

        field { sw=r; hw=rw; desc = "RSVD in SS"; } mailbox_data_avail[5:5] = 1'b0;
        field { sw=r; hw=rw; desc = "RSVD in SS"; } mailbox_flow_done[6:6] = 1'b0;

        field { sw=r; hw=rw; desc = "RSVD in core"; } cptra_ss_mcu_halt_status_o[7:7] = 1'b0;
    } status;

    reg {
        default sw=rw;
        default hw=r;

        field {
            desc = "USER Value passed to AXI Interconnect for transactions initiated from the ARM core";
        } arm_user[32] = 32'b0;
    } arm_user;

    reg {
        default sw=rw;
        default hw=r;

        field {} itrng_divisor[32] = 32'b0;
    } itrng_divisor;

    reg {
        default sw=r;
        default hw=rw;

        field {} cycle_count[32] = 32'b0;
    } cycle_count;

    reg {
        field { sw=rw; hw=r; } value[32] = 32'b0;
    } generic_input_wires[2] @0x30;

    reg {
        field { sw=r; hw=rw; } value[32] = 32'b0;
    } generic_output_wires[2];

    reg {
        default sw=rw;
        default hw=r;

        field {} value[32] = 32'b0;
    } cptra_obf_key[8] @0x40;

    reg {
        default sw=rw;
        default hw=r;

        field {} value[32] = 32'b0;
    } cptra_csr_hmac_key[16];

    reg {
        default sw=rw;
        default hw=r;

        field {} value[32] = 32'b0;
    } cptra_obf_uds_seed[16];

    reg {
        default sw=rw;
        default hw=r;

        field {} value[32] = 32'b0;
    } cptra_obf_field_entropy[8];


    reg {
        default sw=rw;
        default hw=r;

        field {
            desc = "SS USER Strap";
        } lsu_user[32] = 32'b0;
    } lsu_user;
    reg {
        default sw=rw;
        default hw=r;

        field {
            desc = "SS USER Strap";
        } ifu_user[32] = 32'b0;
    } ifu_user;
    reg {
        default sw=rw;
        default hw=r;

        field {
            desc = "SS USER Strap";
        } dma_axi_user[32] = 32'b0;
    } dma_axi_user;
    reg {
        default sw=rw;
        default hw=r;

        field {
            desc = "SS USER Strap";
        } soc_config_user[32] = 32'b0;
    } soc_config_user;
    reg {
        default sw=rw;
        default hw=r;

        field {
            desc = "SS USER Strap";
        } sram_config_user[32] = 32'b0;
    } sram_config_user;
    reg {
        default sw=rw;
        default hw=r;

        field {
            desc = "MCU Reset Vector Strap";
        } mcu_reset_vector[32] = 32'b0;
    } mcu_reset_vector;
    reg {
        field { sw=r; hw=rw; desc = "RSVD in core"; } ss_all_error_fatal = 1'b0;
        field { sw=r; hw=rw; desc = "RSVD in core"; } ss_all_error_non_fatal = 1'b0;
    } ss_all_error;
    reg {
        field { sw=rw; hw=r; } mcu_no_rom_config = 1'b0;
        field { sw=rw; hw=r; } cptra_ss_mci_boot_seq_brkpoint_i = 1'b0;
        field { sw=rw; hw=r; } cptra_ss_lc_Allow_RMA_on_PPD_i = 1'b0;
        field { sw=rw; hw=r; } cptra_ss_lc_ctrl_scan_rst_ni_i = 1'b0;
        field { sw=rw; hw=r; } cptra_ss_lc_esclate_scrap_state0_i = 1'b0;
        field { sw=rw; hw=r; } cptra_ss_lc_esclate_scrap_state1_i = 1'b0;

    } mcu_config;

    reg {
        default sw=rw;
        default hw=r;

        field {} uds_seed_base_addr[32] = 32'b0;
    } uds_seed_base_addr;
    reg {
        default sw=rw;
        default hw=r;

        field {} prod_debug_unlock_auth_pk_hash_reg_bank_offset[32] = 32'b0;
    } prod_debug_unlock_auth_pk_hash_reg_bank_offset;
    reg {
        default sw=rw;
        default hw=r;

        field {} num_of_prod_debug_unlock_auth_pk_hashes[32] = 32'b0;
    } num_of_prod_debug_unlock_auth_pk_hashes;

    reg {
        field { sw=rw; hw=r; } value[32] = 32'b0;
    } mci_generic_input_wires[2];

    reg {
        field { sw=r; hw=rw; } value[32] = 32'b0;
    } mci_generic_output_wires[2];

    reg {
        field { sw=r; hw=rw; desc = "RSVD in core"; } ss_key_release_base_addr[32] = 32'b0;
    } ss_key_release_base_addr;

    reg {
        field { sw=r; hw=rw; desc = "RSVD in core"; } ss_key_release_key_size[16] = 32'b0;
    } ss_key_release_key_size;

    reg {
        field { sw=r; hw=rw; desc = "RSVD in core"; } ss_external_staging_area_base_addr[32] = 32'b0;
    } ss_external_staging_area_base_addr;

    reg {
        field { sw=rw; hw=r; desc = "RSVD in core"; } cptra_ss_mcu_ext_int[31:3] = 29'b0;
    } cptra_ss_mcu_ext_int;

    reg {
        default sw=rw;
        default hw=r;

        field {} value[32] = 32'b0;
    } cptra_ss_raw_unlock_token_hash[4];

    reg {
        field { sw=rw; hw=r; desc = "RSVD in core"; } use_spare_i3c_core[0:0] = 1'b0;
        field { sw=r;  hw=rw; desc = "RSVD in core"; } irq_o[1:1] = 1'b0;
        field { sw=r;  hw=rw; desc = "RSVD in core"; } recovery_payload_available_o[2:2] = 1'b0;
        field { sw=r;  hw=rw; desc = "RSVD in core"; } recovery_image_activated_o[3:3] = 1'b0;

        field { sw=rw; hw=r; desc = "RSVD in core"; } use_ext_i3c_host[31:31] = 1'b0;
    } spare_i3c_control_sts;

    reg {
        field { sw=rw; hw=r; } value[32] = 32'b0;
    } ss_strap_generic[4] @ 0x1F0;

    reg {
        field { sw=rw; hw=na; desc = "OCP LOCK Media Encryption Key (MEK)"; } key[32] = 32'h0;
    } ocp_lock_key_release_reg[16] @ 0x200;

    reg {
        field { sw=rw; hw=na; desc = "OCP LOCK Metadata (METD)"; } metadata[32] = 32'h0;
    } ocp_lock_metadata_reg[5] @ 0x240;

    reg {
        field { sw=rw; hw=na; desc = "OCP LOCK Auxiliary Data (AUX)"; } data[32] = 32'h0;
    } ocp_lock_auxiliary_data_reg[8] @ 0x260;

    reg {
        field { sw=r; hw=rw; desc = "OCP LOCK Ready bit. Sticky bit indicating the engine has processed the MEK."; } rdy[0:0] = 1'b0;
        field { sw=rw; hw=na; desc = "Reserved bits for OCP LOCK Control"; } reserved[31:1] = 31'h0;
    } ocp_lock_control_reg @ 0x280;

    reg {
        default sw=r;
        default hw=na;

        field { desc = "Hardware flash controllers (primary_hw_flash_ctrl_regs, secondary_hw_flash_ctrl_regs) are present."; } hw_flash[0:0] = 1'b1;
        field { desc = "The AXI CDMA interrupt and cdma_axi_user are connected."; } cdma[1:1] = 1'b1;
        field { desc = "SoC RV32 core, its SRAM and the soc_fifo registers are present."; } soc_core[2:2] = 1'b1;
    } fpga_features @ 0x300;

    reg {
        field { sw=rw; hw=r; desc = "Bit of SS_GENERIC_FW_EXEC_CTRL that releases the SoC core from reset. Bits 0 and 1 are not exported by the subsystem and read as 0."; } exec_bit[6:0] = 7'd3;
        field { sw=rw; hw=r; desc = "Hold the SoC core in reset regardless of SS_GENERIC_FW_EXEC_CTRL."; } force_reset[8:8] = 1'b0;
        field { sw=rw; hw=r; desc = "Release the SoC core from reset regardless of SS_GENERIC_FW_EXEC_CTRL. force_reset has priority."; } force_run[9:9] = 1'b0;
    } soc_core_control @ 0x304;

    reg {
        field { sw=r; hw=w; desc = "SoC core reset (active low)."; } rst_b[0:0];
        field { sw=r; hw=w; desc = "SoC core has trapped (illegal instruction, misaligned access or ebreak) and is halted until reset."; } trap[1:1];
    } soc_core_status @ 0x308;

    reg {
        field { sw=rw; hw=r; desc = "USER value passed to the AXI interconnect for transactions initiated by the AXI CDMA."; } cdma_axi_user[32] = 32'b0;
    } cdma_axi_user @ 0x30C;

    reg {
        field { sw=r; hw=w; desc = "SS_GENERIC_FW_EXEC_CTRL as driven by Caliptra. Bits 0 and 1 of the first word read as 0."; } value[32];
    } fw_exec_ctrl[4] @ 0x310;
};

regfile flash_ctrl_regs {
    reg {
        field {
            sw = rw;
            hw = r;
            desc = "Error-related interrupts";
        } ERROR[0:0] = 1'b0;
        field {
            sw = rw;
            hw = r;
            desc = "Event-related interrupts";
        } EVENT[1:1] = 1'b0;
    } FL_INTERRUPT_STATE @ 0x00;

    reg {
        field {
            sw = rw;
            hw = r;
            desc = "Enable error interrupt";
        } ERROR[0:0] = 1'b0;
        field {
            sw = rw;
            hw = r;
            desc = "Enable event interrupt";
        } EVENT[1:1] = 1'b0;
    } FL_INTERRUPT_ENABLE @ 0x04;

    reg {
        field {
            sw = rw;
            hw = na;
            desc = "Page size in bytes (default 256)";
        } PAGE_SIZE[31:0] = 32'd256;
    } PAGE_SIZE @ 0x08;

    reg {
        field {
            sw = rw;
            hw = na;
            desc = "The page number for read, write, erase operations";
        } PAGE_NUM[31:0] = 32'b0;
    } PAGE_NUM @ 0x0C;

    reg {
        field {
            sw = rw;
            hw = na;
            desc = "The page buffer address for read/write operations (driver-provided memory address)";
        } PAGE_ADDR[31:0] = 32'b0;
    } PAGE_ADDR @ 0x10;

    reg {
        field {
            sw = rw;
            hw = na;
            desc = "\"0\" = Read page, \"1\" = Write Page, \"2\" = Erase Page";
        } OP[2:1] = 2'b0;
        field {
            sw = rw;
            hw = na;
            desc = "Start the operation. HW clears when done.";
        } START[0:0] = 1'b0;
    } FL_CONTROL @ 0x14;

    reg {
        field {
            sw = rw;
            hw = na;
            desc = "Flash operation error. \"1\" = Read Error, \"2\" = Write Error, \"4\" = Erase Error";
        } ERR[3:1] = 3'b0;
        field {
            sw = rw;
            hw = na;
            desc = "Flash operation done. Set by HW, cleared by SW";
        } DONE[0:0] = 1'b0;
    } OP_STATUS @ 0x18;

    reg {
        field {
            sw = rw;
            hw = na;
            desc = "Control register write enable. 1=unlocked, 0=locked during operation";
        } EN[0:0] = 1'b1;
    } CTRL_REGWEN @ 0x1C;

    reg {
        field {
            sw = rw;
            hw = na;
            desc = "Total flash size in bytes";
        } FLASH_SIZE[31:0] = 32'h0100_0000;
    } FLASH_SIZE @ 0x20;

    reg {
        field { sw=rw; hw=na; } FLASH_BUF[32] = 32'hffffffff;
        desc = "Flash buffer";
    } FLASH_BUF[64] @ 0x100;
};

regfile fifo_regs {
    reg {
        field { sw=r; hw=rw; rd_swacc=true; } next_char[8] = 8'b0;
        field { sw=r; hw=rw; } char_valid = 1'b0;
    } log_fifo_data;

    reg {
        field { sw=r; hw=rw; } log_fifo_empty = 1'b0;
        field { sw=r; hw=rw; } log_fifo_full = 1'b0;
    } log_fifo_status;

    reg {
        field { sw=rw; hw=r; wr_swacc=true; } itrng_data[32] = 32'b0;
    } itrng_fifo_data;

    reg {
        field { sw=r; hw=rw; } itrng_fifo_empty = 1'b0;
        field { sw=r; hw=rw; } itrng_fifo_full = 1'b0;
        field { sw=rw; hw=r; } itrng_fifo_reset = 1'b0;
    } itrng_fifo_status;

    reg {
        field { sw=r; hw=rw; rd_swacc=true; desc = "RSVD in core"; } out_data[32] = 32'b0;
    } dbg_fifo_pop;

    reg {
        field { sw=rw; hw=r; wr_swacc=true; desc = "RSVD in core"; } in_data[32] = 32'b0;
    } dbg_fifo_push;

    reg {
        field { sw=r; hw=rw; desc = "RSVD in core"; } dbg_fifo_empty = 1'b0;
        field { sw=r; hw=rw; desc = "RSVD in core"; } dbg_fifo_full = 1'b0;
    } dbg_fifo_status;

    reg {
        field { sw=r; hw=rw; rd_swacc=true; desc = "RSVD in core"; } out_data[32] = 32'b0;
    } msg_fifo_pop;

    reg {
        field { sw=rw; hw=r; wr_swacc=true; desc = "RSVD in core"; } in_data[32] = 32'b0;
    } msg_fifo_push;

    reg {
        field { sw=r; hw=rw; desc = "RSVD in core"; } msg_fifo_empty = 1'b0;
        field { sw=r; hw=rw; desc = "RSVD in core"; } msg_fifo_full = 1'b0;
    } msg_fifo_status;

    reg {
        field { sw=r; hw=w; rd_swacc=true; desc = "Next byte written by the SoC core. Reading removes it from the FIFO."; } out_data[7:0];
        field { sw=r; hw=w; desc = "out_data is valid."; } valid[8:8];
    } soc_fifo_pop @ 0x28;

    reg {
        field { sw=rw; hw=r; wr_swacc=true; desc = "Byte to send to the SoC core. Dropped if the FIFO is full."; } in_data[7:0] = 8'b0;
    } soc_fifo_push @ 0x2C;

    reg {
        field { sw=r; hw=w; desc = "FIFO from the SoC core is empty."; } to_host_empty[0:0];
        field { sw=r; hw=w; desc = "FIFO from the SoC core is full."; } to_host_full[1:1];
        field { sw=r; hw=w; desc = "FIFO to the SoC core is empty."; } to_core_empty[2:2];
        field { sw=r; hw=w; desc = "FIFO to the SoC core is full."; } to_core_full[3:3];
    } soc_fifo_status @ 0x30;
};

regfile hw_flash_ctrl_regs {
    desc = "Flash controller implemented in the FPGA and backed by on-chip RAM.
            The register layout matches flash_ctrl_regs. The flash contents are also
            mapped directly on the AXI bus; see the Versal memory map.";

    reg {
        field { sw=rw; onwrite=woclr; hw=w; desc = "An operation finished with an error. Write 1 to clear."; } ERROR[0:0] = 1'b0;
        field { sw=rw; onwrite=woclr; hw=w; desc = "An operation finished. Write 1 to clear."; } EVENT[1:1] = 1'b0;
    } FL_INTERRUPT_STATE @ 0x00;

    reg {
        field { sw=rw; hw=r; desc = "Enable error interrupt"; } ERROR[0:0] = 1'b0;
        field { sw=rw; hw=r; desc = "Enable event interrupt"; } EVENT[1:1] = 1'b0;
    } FL_INTERRUPT_ENABLE @ 0x04;

    reg {
        field { sw=rw; hw=r; desc = "Page size in bytes. The controller uses 256 byte pages; an operation fails if this is less than 256."; } PAGE_SIZE[31:0] = 32'd256;
    } PAGE_SIZE @ 0x08;

    reg {
        field { sw=rw; hw=r; desc = "The page number for read, write, erase operations"; } PAGE_NUM[31:0] = 32'b0;
    } PAGE_NUM @ 0x0C;

    reg {
        field { sw=rw; hw=na; desc = "Not used by the controller. Page data is exchanged through FLASH_BUF."; } PAGE_ADDR[31:0] = 32'b0;
    } PAGE_ADDR @ 0x10;

    reg {
        field { sw=rw; hw=r; desc = "\"1\" = Read page into FLASH_BUF, \"2\" = Write page from FLASH_BUF, \"3\" = Erase the 4 KiB sector containing the page"; } OP[2:1] = 2'b0;
        field { sw=rw; hw=rw; desc = "Start the operation. Cleared by hardware when done."; } START[0:0] = 1'b0;
    } FL_CONTROL @ 0x14;

    reg {
        field { sw=rw; hw=rw; desc = "Flash operation error. Set by hardware, cleared by software. \"1\" = Read Error, \"2\" = Write Error, \"4\" = Erase Error. An invalid operation code reports a read error."; } ERR[3:1] = 3'b0;
        field { sw=rw; hw=rw; desc = "Flash operation done. Set by hardware, cleared by software."; } DONE[0:0] = 1'b0;
    } OP_STATUS @ 0x18;

    reg {
        field { sw=r; hw=w; desc = "1 when idle. 0 while an operation is running; writes to PAGE_SIZE, PAGE_NUM, FL_CONTROL and FLASH_BUF are then ignored."; } EN[0:0] = 1'b1;
    } CTRL_REGWEN @ 0x1C;

    reg {
        field { sw=r; hw=w; desc = "Total flash size in bytes"; } FLASH_SIZE[31:0];
    } FLASH_SIZE @ 0x20;

    reg {
        field { sw=rw; hw=rw; } FLASH_BUF[32] = 32'h0;
        desc = "Page buffer";
    } FLASH_BUF[64] @ 0x100;
};

addrmap caliptra_fpga_realtime_regs {
    default regwidth = 32;
    default accesswidth = 32;

    interface_regs interface_regs @ 0xA4010000;
    fifo_regs fifo_regs @ 0xA4011000;
    flash_ctrl_regs primary_flash_ctrl_regs @ 0xA4012000;
    flash_ctrl_regs secondary_flash_ctrl_regs @ 0xA4013000;
    external hw_flash_ctrl_regs primary_hw_flash_ctrl_regs @ 0xA4014000;
    external hw_flash_ctrl_regs secondary_hw_flash_ctrl_regs @ 0xA4015000;
};
